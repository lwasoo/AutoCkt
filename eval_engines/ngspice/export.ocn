openResults("2opamp.raw")
selectResult("ac")
ocnPrint(?output "ac.csv" v("VOUT") ?numberNotation "scientific")
selectResult("dcOp")
ocnPrint(?output "dc.csv" i("V1:p") ?numberNotation "scientific")
exit()
