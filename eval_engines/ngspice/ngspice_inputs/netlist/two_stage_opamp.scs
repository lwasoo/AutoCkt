// Design: Test_library/test_2_tb
simulator lang=spectre
global 0
include "$SPECTRE_MODEL_PATH/design_wrapper.lib.scs" section=mainlib
include "$SPECTRE_MODEL_PATH/design_wrapper.lib.scs" section=FET_tt_pre
include "$SPECTRE_MODEL_PATH/design_wrapper.lib.scs" section=Res_nom
include "$SPECTRE_MODEL_PATH/design_wrapper.lib.scs" section=MOSCap_nom
include "$SPECTRE_MODEL_PATH/design_wrapper.lib.scs" section=APMOMCap_nom
include "$SPECTRE_MODEL_PATH/design_wrapper.lib.scs" section=MIMCap_nom
include "$SPECTRE_MODEL_PATH/design_wrapper.lib.scs" section=Ind_nom
include "$SPECTRE_MODEL_PATH/design_wrapper.lib.scs" section=DioCap_nom

// Test_library/test_2/schematic
subckt test_2 VDD VSS vin\+ vin\- vout vout_test
    MN6 (net02 net02 VSS VSS) dgxnfet l=500n w=1.5u m=1 nf=1 par_nf=(1) plnest=1 pld200=1 dtemp=0.0 p_vta=0 pre_layout_local=-1
    MN2 (vout_test vin\+ net9 net9) dgxnfet l=500n w=1.5u m=1 nf=1 par_nf=(1) plnest=1 pld200=1 dtemp=0.0 p_vta=0 pre_layout_local=-1
    MN7 (vout net02 VSS VSS) dgxnfet l=500n w=30u m=1 nf=1 par_nf=(1) plnest=1 pld200=1 dtemp=0.0 p_vta=0 pre_layout_local=-1
    MN5 (net9 net02 VSS VSS) dgxnfet l=500n w=6u m=1 nf=1 par_nf=(1) plnest=1 pld200=1 dtemp=0.0 p_vta=0 pre_layout_local=-1
    MN1 (net10 vin\- net9 net9) dgxnfet l=500n w=1.5u m=1 nf=1 par_nf=(1) plnest=1 pld200=1 dtemp=0.0 p_vta=0 pre_layout_local=-1
    MP2 (vout vout_test VDD VDD) dgxpfet l=400n w=36u m=1 nf=1 par_nf=(1) plnest=1 pld200=1 dtemp=0.0 p_vta=0 pre_layout_local=-1
    MP1 (net10 net10 VDD VDD) dgxpfet l=500n w=6u m=1 nf=1 par_nf=(1) plnest=1 pld200=1 dtemp=0.0 p_vta=0 pre_layout_local=-1
    MP0 (vout_test net10 VDD VDD) dgxpfet l=500n w=6u m=1 nf=1 par_nf=(1) plnest=1 pld200=1 dtemp=0.0 p_vta=0 pre_layout_local=-1
    Cc (vout vout_test) capacitor c=3.3p
    I4 (VDD net02) isource dc=10u type=dc
ends test_2

// Test_library/test_2_tb/schematic
I0 (net011 0 net02 net03 Vout vout_test) test_2
V5 (net02 0) vsource dc=1.8 mag=1 phase=0 type=dc
V9 (net03 0) vsource dc=1.8 mag=1 phase=180 type=dc
VDD (net011 0) vsource dc=3.3 type=dc
CL (Vout 0) capacitor c=2p
C0 (vout_test 0) capacitor c=5p
simulatorOptions options temp=27 ivthw=0 ivthl=0 vdsatmod=gds
ac ac start=1 stop=100M
dcOp dc
save Vout
